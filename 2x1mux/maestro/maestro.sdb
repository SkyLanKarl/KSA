ADE simulation setup
Run mode: Single Run, Sweeps and Corners
Tests:
  KoggeStone_ALU_mux_2to1_1: KoggeStone_ALU/mux_2to1/schematic, simulator spectre
    Outputs: /In_1; /In_2; /Select; /Output
