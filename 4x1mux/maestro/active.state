ADE simulation setup
Test KoggeStone_ALU_4x1mux_1: KoggeStone_ALU/4x1mux/schematic, simulator spectre
  Models: /util-cse/cadence/local/gpdk045_v_6_0/gpdk045/../models/spectre/gpdk045.scs[mc]
  Temperature: 27
  Stimulus vdd!: voltage dc dc=1 srcType=dc
  Stimulus A: voltage pulse val0=0 val1=1 period=2n width=1n srcType=pulse
  Stimulus B: voltage pulse val0=0 val1=1 period=4n width=2n srcType=pulse
  Stimulus C: voltage pulse val0=0 val1=1 period=8n width=4n srcType=pulse
  Stimulus D: voltage pulse val0=0 val1=1 period=16n width=8n srcType=pulse
  Stimulus A0: voltage pulse val0=0 val1=1 period=16n width=8n srcType=pulse
  Stimulus A1: voltage pulse val0=0 val1=1 period=32n width=16n srcType=pulse
  Analysis tran: stop=64n
  Signals: /A, /B, /C, /D, /A0, /A1, /out
Run mode: Single Run, Sweeps and Corners
