ADE simulation setup
Run mode: Single Run, Sweeps and Corners
Tests:
  KoggeStone_ALU_4x1mux_1: KoggeStone_ALU/4x1mux/schematic, simulator spectre
    Outputs: /A; /B; /C; /D; /A0; /A1; /out
