ADE simulation setup
Test KoggeStone_ALU_8x1mux_1: KoggeStone_ALU/8x1mux/schematic, simulator spectre
  Models: /util-cse/cadence/local/gpdk045_v_6_0/gpdk045/../models/spectre/gpdk045.scs[mc]
  Temperature: 27
  Stimulus vdd!: voltage dc dc=1 srcType=dc
  Stimulus A: voltage pulse val0=0 val1=1 period=2n width=1n srcType=pulse
  Stimulus B: voltage pulse val0=0 val1=1 period=4n width=2n srcType=pulse
  Stimulus C: voltage pulse val0=0 val1=1 period=8n width=4n srcType=pulse
  Stimulus D: voltage pulse val0=0 val1=1 period=16n width=8n srcType=pulse
  Stimulus E: voltage pulse val0=0 val1=1 period=6n width=3n srcType=pulse
  Stimulus F: voltage pulse val0=0 val1=1 period=12n width=6n srcType=pulse
  Stimulus G: voltage pulse val0=0 val1=1 period=22n width=11n srcType=pulse
  Stimulus H: voltage pulse val0=0 val1=1 period=26n width=13n srcType=pulse
  Stimulus S0: voltage pulse val0=0 val1=1 period=4n width=2n srcType=pulse
  Stimulus S1: voltage pulse val0=0 val1=1 period=8n width=4n srcType=pulse
  Stimulus S2: voltage pulse val0=0 val1=1 period=16n width=8n srcType=pulse
  Analysis tran: stop=64n
  Signals: /A, /B, /C, /D, /E, /F, /G, /H, /S0, /S1, /S2, /out
Run mode: Single Run, Sweeps and Corners
