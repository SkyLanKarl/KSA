ADE simulation setup
Run mode: Single Run, Sweeps and Corners
Tests:
  KoggeStone_ALU_8x1mux_1: KoggeStone_ALU/8x1mux/schematic, simulator spectre
    Outputs: /A; /B; /C; /D; /E; /F; /G; /H; /S0; "/S1"; /S1; /S2; /out
