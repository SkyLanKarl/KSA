ADE simulation setup
Test KoggeStone_ALU_OR_1: KoggeStone_ALU/OR/schematic, simulator spectre
  Models: /util-cse/cadence/local/gpdk045_v_6_0/gpdk045/../models/spectre/gpdk045.scs[mc]
  Temperature: 27
  Stimulus B: voltage pulse val0=0 val1=1 period=2n rise=10p fall=10p width=1n srcType=pulse
  Stimulus A: voltage pulse val0=0 val1=1 period=4n rise=10p fall=10p width=2n srcType=pulse
  Stimulus vdd!: voltage dc dc=1 srcType=dc
  Analysis tran: stop=16n
  Signals: /A, /B, /out
Run mode: Single Run, Sweeps and Corners
