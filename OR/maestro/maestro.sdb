ADE simulation setup
Run mode: Single Run, Sweeps and Corners
Tests:
  KoggeStone_ALU_OR_1: KoggeStone_ALU/OR/schematic, simulator spectre
    Outputs: /; /A; /B; /out
