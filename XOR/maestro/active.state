ADE simulation setup
Test KSA_XOR_1: KSA/XOR/schematic, simulator spectre
  Models: /util-cse/cadence/local/gpdk045_v_6_0/gpdk045/../models/spectre/gpdk045.scs[mc]
  Temperature: 27
  Stimulus A: voltage pulse dc=0 val0=0 val1=1 period=2n width=1n srcType=pulse
  Stimulus B: voltage pulse dc=0 val0=0 val1=1 period=4n width=2n srcType=pulse
  Stimulus vdd!: voltage dc dc=1 srcType=dc
  Analysis tran: stop=8n
  Signals: /A, /B, /vout
Run mode: Single Run, Sweeps and Corners
