ADE simulation setup
Run mode: Single Run, Sweeps and Corners
Tests:
  KSA_XOR_1: KSA/XOR/schematic, simulator spectre
    Outputs: /A; /B; /vout
