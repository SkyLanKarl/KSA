ADE simulation setup
Run mode: Single Run, Sweeps and Corners
Tests:
  KoggeStone_ALU_and_1: KoggeStone_ALU/and/schematic, simulator spectre
    Outputs: /A; /B; /Out
