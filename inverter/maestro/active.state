ADE simulation setup
Test lab1_inverter_1: lab1/inverter/schematic, simulator spectre
  Models: /util-cse/cadence/local/gpdk045_v_6_0/gpdk045/../models/spectre/gpdk045.scs[mc]
  Temperature: 27
  Stimulus in: voltage pulse val0=0 val1=1 period=2n rise=0 fall=0 width=1n srcType=pulse
  Stimulus vdd!: voltage dc dc=1 srcType=dc
  Analysis tran: stop=4n
  Signals: /in, /out
Run mode: Single Run, Sweeps and Corners
