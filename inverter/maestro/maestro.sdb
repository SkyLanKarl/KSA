ADE simulation setup
Run mode: Single Run, Sweeps and Corners
Tests:
  lab1_inverter_1: lab1/inverter/schematic, simulator spectre
    Outputs: /in; "/333333333333333333333333333333333333333333"; "/out"; /out
