ADE simulation setup
Test KoggeStone_ALU_mux_2to1_1: KoggeStone_ALU/mux_2to1/schematic, simulator spectre
  Models: /util-cse/cadence/local/gpdk045_v_6_0/gpdk045/../models/spectre/gpdk045.scs[mc]
  Temperature: 27
  Stimulus vdd!: voltage dc dc=1 srcType=dc
  Stimulus In_1: voltage pulse val0=0 val1=1 period=8n rise=10p fall=10p width=4n srcType=pulse
  Stimulus In_2: voltage pulse val0=0 val1=1 period=4n rise=10p fall=10p width=2n srcType=pulse
  Stimulus Select: voltage pulse val0=0 val1=1 period=2n rise=10p fall=10p width=1n srcType=pulse
  Analysis tran: stop=16n
  Signals: /In_1, /In_2, /Select, /Output
