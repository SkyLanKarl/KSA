ADE simulation setup
Test CSE493_or_1: CSE493/or/schematic, simulator spectre
  Models: /util-cse/cadence/local/gpdk045_v_6_0/gpdk045/../models/spectre/gpdk045.scs[mc]
  Temperature: 27
  Stimulus in_b: voltage pulse dc=0 val0=0 val1=1 period=4n width=2n srcType=pulse
  Stimulus in_a: voltage pulse dc=0 val0=0 val1=1 period=2n width=1n srcType=pulse
  Stimulus vdd!: voltage dc dc=1 srcType=dc
  Analysis tran: stop=16n
  Signals: /in_a, /in_b, /out
Run mode: Single Run, Sweeps and Corners
