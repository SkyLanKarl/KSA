ADE simulation setup
Run mode: Single Run, Sweeps and Corners
Tests:
  CSE493_or_1: CSE493/or/schematic, simulator spectre
    Outputs: /in_a; /in_b; /out
