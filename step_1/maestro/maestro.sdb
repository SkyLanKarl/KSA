ADE simulation setup
Run mode: Single Run, Sweeps and Corners
Tests:
  KSA_step_1_1: KSA/step_1/schematic, simulator spectre
    Outputs: /G00; /G01; /P01; /G02; /P02; /P03; /G03; /G10; /G11; /P12; /G12; /P13; /G13
