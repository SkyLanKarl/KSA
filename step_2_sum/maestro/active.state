ADE simulation setup
Test KSA_step_2_sum_1: KSA/step_2_sum/schematic, simulator spectre
  Models: /util-cse/cadence/local/gpdk045_v_6_0/gpdk045/../models/spectre/gpdk045.scs[mc]
  Temperature: 27
  Stimulus Cin: voltage pulse val0=0 val1=1 period=2n width=1n srcType=pulse
  Stimulus P00: voltage pulse val0=0 val1=1 period=2n width=1n srcType=pulse
  Stimulus G10: voltage pulse val0=0 val1=1 period=4n width=2n srcType=pulse
  Stimulus G11: voltage pulse val0=0 val1=1 period=8n width=4n srcType=pulse
  Stimulus G12: voltage pulse val0=0 val1=1 period=16n width=8n srcType=pulse
  Stimulus P01: voltage pulse val0=0 val1=1 period=4n width=2n srcType=pulse
  Stimulus P02: voltage pulse val0=0 val1=1 period=16n width=8n srcType=pulse
  Stimulus P12: voltage pulse val0=0 val1=1 period=8n width=4n srcType=pulse
  Stimulus G00: voltage pulse val0=0 val1=1 period=2n width=1n srcType=pulse
  Stimulus G13: voltage pulse val0=0 val1=1 period=4n width=2n srcType=pulse
  Stimulus P13: voltage pulse val0=0 val1=1 period=8n width=4n srcType=pulse
  Stimulus P03: voltage pulse val0=0 val1=1 period=16n width=8n srcType=pulse
  Stimulus vdd!: voltage dc dc=1 srcType=dc
  Analysis tran: stop=16n
  Signals: /Cin, /P00, /G10, /P01, /G11, /P02, /G12, /P12, /G00, /P03, /G13, /P13, /S0, /S1, /S2, /S3, /Cout
Run mode: Single Run, Sweeps and Corners
