ADE simulation setup
Run mode: Single Run, Sweeps and Corners
Tests:
  KSA_step_2_sum_1: KSA/step_2_sum/schematic, simulator spectre
    Outputs: /Cin; /P00; /G10; /P01; /G11; /P02; /G12; /P12; /G00; /P03; /G13; /P13; /S0; /S1; /S2; /S3; /Cout
