ADE simulation setup
Test KSA_step_pre_0_1: KSA/step_pre_0/schematic, simulator spectre
  Models: /util-cse/cadence/local/gpdk045_v_6_0/gpdk045/../models/spectre/gpdk045.scs[mc]
  Temperature: 27
  Stimulus A0: voltage pulse val0=0 val1=1 period=2n width=1n srcType=pulse
  Stimulus B0: voltage pulse val0=0 val1=1 period=8n width=4n srcType=pulse
  Stimulus Cin: voltage pulse val0=0 val1=0 period=16n width=8n srcType=pulse
  Stimulus A3: voltage pulse val0=0 val1=1 period=8n width=4n srcType=pulse
  Stimulus B3: voltage pulse val0=0 val1=1 period=16n width=8n srcType=pulse
  Stimulus B2: voltage pulse val0=0 val1=1 period=8n width=4n srcType=pulse
  Stimulus A2: voltage pulse val0=0 val1=1 period=8n width=4n srcType=pulse
  Stimulus B1: voltage pulse val0=0 val1=1 period=4n width=2n srcType=pulse
  Stimulus A1: voltage pulse val0=0 val1=1 period=8n width=4n srcType=pulse
  Stimulus vdd!: voltage dc dc=1 srcType=dc
  Analysis tran: stop=16n
  Signals: /A0, /B0, /Cin, /G0a, /G0b, /G0c, /P00, /G00, /A1, /B1, /A2, /B2, /A3, /B3, /P01, /G01, /P02, /G02, /P03, /G03
Run mode: Single Run, Sweeps and Corners
