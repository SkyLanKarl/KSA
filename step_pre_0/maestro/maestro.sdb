ADE simulation setup
Run mode: Single Run, Sweeps and Corners
Tests:
  KSA_step_pre_0_1: KSA/step_pre_0/schematic, simulator spectre
    Outputs: /A0; /B0; /Cin; /G0a; /G0b; /G0c; /P00; /G00; /A1; /B1; /A2; /B2; /A3; /B3; /P01; /G01; /P02; /G02; /P03; /G03
