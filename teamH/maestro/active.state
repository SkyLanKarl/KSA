ADE simulation setup
Test KSA_teamH_1: KSA/teamH/schematic, simulator spectre
  Models: /util-cse/cadence/local/gpdk045_v_6_0/gpdk045/../models/spectre/gpdk045.scs[mc]
  Temperature: 27
  Stimulus vdd!: voltage dc dc=1 srcType=dc
  Stimulus A0: voltage pulse val0=0 val1=1 period=2n width=1n srcType=pulse
  Stimulus A1: voltage pulse val0=0 val1=1 period=4n width=2n srcType=pulse
  Stimulus A2: voltage pulse val0=0 val1=1 period=8n width=4n srcType=pulse
  Stimulus A3: voltage pulse val0=0 val1=1 period=16n width=8n srcType=pulse
  Stimulus B0: voltage pulse val0=0 val1=1 period=2n width=1n srcType=pulse
  Stimulus B1: voltage pulse val0=0 val1=1 period=4n width=2n srcType=pulse
  Stimulus B2: voltage pulse val0=0 val1=1 period=8n width=4n srcType=pulse
  Stimulus B3: voltage pulse val0=0 val1=1 period=16n width=8n srcType=pulse
  Stimulus Cin: voltage pulse val0=0 val1=0 period=16n width=1n srcType=pulse
  Analysis tran: stop=16n
  Signals: /A0, /A1, /A2, /A3, /B0, /B1, /B2, /B3, /Cin, /Cout, /S0, /S1, /S2, /net7, /S3, /net3
Run mode: Single Run, Sweeps and Corners
