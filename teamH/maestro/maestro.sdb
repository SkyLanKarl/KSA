ADE simulation setup
Run mode: Single Run, Sweeps and Corners
Tests:
  KSA_teamH_1: KSA/teamH/schematic, simulator spectre
    Outputs: /A0; /A1; /A2; /A3; /B0; /B1; /B2; /B3; /Cin; /Cout; /S0; /S1; /S2; /S3; /net7; /net3
