ADE simulation setup
Test KSA_teamH_test_1: KSA/teamH_test/schematic, simulator spectre
  Models: /util-cse/cadence/local/gpdk045_v_6_0/gpdk045/../models/spectre/gpdk045.scs[mc]
  Temperature: 27
  Stimulus vdd!: voltage dc dc=1 srcType=dc
  Stimulus Cin: voltage pulse dc=0 val0=0 val1=0 period=2n width=1n srcType=pulse
  Stimulus B3: voltage pulse dc=0 val0=0 val1=1 period=16n width=8n srcType=pulse
  Stimulus B0: voltage pulse dc=0 val0=0 val1=1 period=2n width=1n srcType=pulse
  Stimulus A3: voltage pulse dc=0 val0=0 val1=1 period=16n width=8n srcType=pulse
  Stimulus B2: voltage pulse dc=0 val0=0 val1=1 period=8n width=4n srcType=pulse
  Stimulus A2: voltage pulse dc=0 val0=0 val1=1 period=8n width=4n srcType=pulse
  Stimulus A0: voltage pulse dc=0 val0=0 val1=1 period=2n width=1n srcType=pulse
  Stimulus B1: voltage pulse dc=0 val0=0 val1=1 period=4n width=2n srcType=pulse
  Stimulus A1: voltage pulse dc=0 val0=0 val1=1 period=4n width=2n srcType=pulse
  Analysis tran: stop=16n
  Signals: /A0, /B0, /A1, /B1, /A2, /B2, /A3, /B3, /Cin, /S0, /S1, /S2, /S3, /Cout, /G11, /P02
Run mode: Single Run, Sweeps and Corners
