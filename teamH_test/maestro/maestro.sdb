ADE simulation setup
Run mode: Single Run, Sweeps and Corners
Tests:
  KSA_teamH_test_1: KSA/teamH_test/schematic, simulator spectre
    Outputs: /A0; /B0; /A1; /B1; /A2; /B2; /A3; /B3; /Cin; /S0; /S1; /S2; /S3; /Cout; /P00; /G11; /P02
