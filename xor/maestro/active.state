ADE simulation setup
Test Lab1_xor_1: Lab1/xor/schematic, simulator spectre
  Models: /util-cse/cadence/local/gpdk045_v_6_0/gpdk045/../models/spectre/gpdk045.scs[mc]
  Temperature: 27
  Stimulus vdd!: voltage dc dc=1 srcType=dc
  Stimulus A: voltage pulse val0=0 val1=1 period=2n width=1n srcType=pulse
  Stimulus B: voltage pulse val0=0 val1=1 period=4n width=2n srcType=pulse
  Analysis tran: stop=4n
  Signals: /A, /B, /out
Run mode: Single Run, Sweeps and Corners
